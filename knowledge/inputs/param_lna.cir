.PARAM
+ L1 = 1.244817861319422e-07
+ L2 = 1.244817861319422e-07
+ L3 = 1.244817861319422e-07
+ W1 = 388.83014601205556e-06
+ W2 = 188.83014601205556e-06
+ W3 = 188.83014601205556e-06
+ Rb = 10000
+ Rb_2 = 8000
+ do_l_1 = 0.00007550469179617822
+ do_l_2 = 0.00007550469179617822
+ do_l_3 = 0.00007550469179617822
+ wo_l_1 = 2.2374167218443724e-06
+ wo_l_2 = 2.0374167218443724e-06
+ wo_l_3 = 5.2374167218443724e-06
