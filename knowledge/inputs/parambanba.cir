.PARAM
+ LM1 = 0.5e-06
+ LM2 = 0.5e-06
+ LM3 = 0.5e-06
+ LM4 = 0.5e-06
+ LM5 = 0.5e-06
+ WM1 = 10e-06
+ WM2 = 1e-06
+ WM3 = 1e-06
+ WM4 = 1e-06
+ WM5 = 1e-06
+ Rb = 8500
+ Rb1 = 52796
+ Rb2 = 8796
