.PARAM
+ WM1 = 0.0002999999823789032
+ WM2 = 1.3905138157098184e-06
+ WM3 = 1.0001557844349576e-06
+ WM4 = 0.0002647118572860083
+ WM6 = 1.0005904977264842e-06
+ WM7 = 1.0000007293155506e-06
+ WM11 = 1.839809354943167e-06
+ Rbias = 49999.98471961436
+ Ccomp = 0.4e-12
+ Rcomp = 1000
