.PARAM
+ LM1 = 1.3905138157098184e-06
+ LM2 = 1.3905138157098184e-06
+ LM3 = 1.3905138157098184e-06
+ LM4 = 1.3905138157098184e-06
+ LM5 = 1.3905138157098184e-06
+ LM6 = 1.3905138157098184e-06
+ LM7 = 1.3905138157098184e-06
+ LM8 = 1.3905138157098184e-06
+ WM1 = 1.3905138157098184e-06
+ WM2 = 1.3905138157098184e-06
+ WM3 = 1.0001557844349576e-06
+ WM4 = 1.3905138157098184e-06
+ WM5 = 1.0005904977264842e-06
+ WM6 = 1.0005904977264842e-06
+ WM7 = 1.0000007293155506e-06
+ WM8 = 1.839809354943167e-06
+ Rb = 12299.98471961436
+ Vcm1 = 0.01
+ Vcm2 = 0.02
+ Vb = 0.3
