.PARAM
+ L1 = 3.0077e-07
+ L2 = 3.1844e-07
+ L3 = 3.3488e-07
+ W1 = 5.7302e-05
+ W2 = 5.2495e-05
+ W3 = 6.3456e-05
+ Ib = 0.0056751
+ cap_w = 3.4049e-05
+ cap_l = 3.5693e-05
+ do_l = 0.00010714
+ wo_l = 5.6098e-06
+ nt_l = 3.5
+ s_l = 2e-06
