.PARAM
+ WM1 = 7e-06
+ WM2 = 3e-06
+ WM3 = 1.0001557844349576e-06
+ WM4 = 6e-06
+ Lcm = 1e-06
