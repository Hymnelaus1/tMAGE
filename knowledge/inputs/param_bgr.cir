.PARAM
+ WM1 = 9.712397071401546e-06
+ WM2 = 7.890300201690659e-06
+ WM3 = 9.990964533074286e-06
+ WM4 = 2.0485594866522886e-06
+ WM5 = 9.141118236022172e-06
+ LM1 = 1.000081755250438e-06
+ LM2 = 9.723117171382962e-05
+ LM3 = 2.1945156307081387e-06
+ LM4 = 1.0479105815001064e-06
+ LM5 = 5.9774732088703326e-05
+ Rb12 = 999796.3683158268
+ Rb3 = 97605.30578884861
+ Rb4 = 433651.7481408305
