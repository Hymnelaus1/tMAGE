.PARAM
+ LM1 =  2.969029726917603e-07
+ LM2 =  1.2058992268608258e-07
+ LM3 =  1.4275497966127279e-07
+ WM1 =  0.00010429795402295988
+ WM2 =  0.00024855297314616156
+ WM3 =  0.00022515976174278203
+ R_1 =  14727.034119579503
+ R_2 = 14475.738294130908
+ do_l1 = 0.00010120528493804486
+ do_l2 = 0.00014891814905714578
+ do_l3 = 7.512022845790907e-05
+ wo_l1 = 4.708401992105799e-06
+ wo_l2 = 2.4836372291118e-06
+ wo_l3 = 9.98101408647341e-06
+ st_l1 = 1.708401992105799e-06
+ st_l2 = 1.6836372291118e-06
+ st_l3 = 1.98101408647341e-06
+ nt_l1 = 5.5
+ nt_l2 = 5
+ nt_l3 = 3
