.PARAM
+ LM1 = 3.881076605701929e-06
+ LM2 = 1.3397687265614544e-06
+ LM3 = 8.799737813822702e-07
+ WM1 = 1.2304277529492461e-05
+ WM2 = 9.569964560390431e-05
+ WM3 = 0.00013204871005067796
+ Rb = 7695.6921892871205
