.PARAM
+ LM1 = 1.839809354943167e-07
+ LM2 = 1.839809354943167e-07
+ LM3 = 1.839809354943167e-07
+ LM4 = 1.839809354943167e-07
+ LM5 = 1.839809354943167e-07
+ WM1 = 1.839809354943167e-07
+ WM2 = 1.3905138157098184e-06
+ WM3 = 1.0001557844349576e-06
+ WM4 = 9.0001557844349576e-06
+ WM5 = 1.0005904977264842e-06
+ Rbias = 49999.98471961436
+ Ccomp = 0.4e-12
+ Vb = 0.5
